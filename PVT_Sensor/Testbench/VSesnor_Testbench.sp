simulator lang=spectre
global 0 vdd!
parameters VDD
// insest target netlist here
I9 (net2 0) isource dc=250n type=dc
I0 (net2 Q QB QBP QP 0 vdd! vdd!) Layout_vdd_sensor_SN
V0 (vdd! 0) vsource type=pwl wave=[ 0 0 50n 0 50.05n VDD 52n VDD 52.05n 0 70n 0 70.05n VDD ]
simulatorOptions options temp=27 tnom=25
