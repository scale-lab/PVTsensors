simulator lang=spectre
global 0
parameters vdd
// insest target netlist here
V1 (gnd 0) vsource dc=0 type=dc
V0 (vdd_pin 0) vsource dc=1.8 type=dc
V8 (vdd 0) vsource type=pwl wave=[ 0 0 50n 0 50.05n vdd 52n vdd 52.05n 0 70n 0 70.05n vdd ]
I18 (IREF 0) isource dc=1u type=dc
simulatorOptions options temp=27 tnom=25
