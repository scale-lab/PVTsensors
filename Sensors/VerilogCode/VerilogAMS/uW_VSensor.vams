// This design is based on tsmc 180nm technology. Please replace '/*Target Process Technology*/' with your target technology library!
// Design cell name: uW_VSensor
// 'nch' stands for N-channel
// 'pch' stands for P-channel
// 'mimcap' stands for MIM capacitor

`include "disciplines.vams"

(* cds_ams_schematic *)
module uW_VSensor_ams ( QBP,QP,vdd_pin,QB,gnd,
Q,vdd,IREF );

output   QBP;
output   QP;
inout   vdd_pin;
output   QB;
inout
 gnd;
output   Q;
inout   vdd;
input   IREF;

pch #(.w(2u), .m(2), .nf(1), .l(300n)) (*
integer library_binding
 = "/*Target Process Technology*/";
integer passed_mfactor = "m";
 *)
M2 ( net0126, ZN_2, vdd,
vdd );
pch #(.w(2u), .m(2), .nf(1), .l(300n)) (*
integer library_binding
 = "/*Target Process Technology*/";
integer passed_mfactor = "m";
 *)
M42 ( ZN_1, S, net0126,
vdd );
pch #(.w(2u), .m(2), .nf(1), .l(300n)) (*
integer library_binding
 = "/*Target Process Technology*/";
integer passed_mfactor = "m";
 *)
M41 ( Q, ZN_1, vdd, vdd );
pch #(.w(2u), .m(2), .nf(1), .l(300n)) (*
integer library_binding
 = "/*Target Process Technology*/";
integer passed_mfactor = "m";
 *)
M40 ( net0105, Q,
vdd_pin, vdd_pin );
pch #(.w(2u), .m(2), .nf(1), .l(300n)) (*
integer library_binding
 = "/*Target Process Technology*/";
integer passed_mfactor = "m";
 *)
M39 ( QP, net0105,
vdd_pin, vdd_pin );
pch #(.w(3u), .m(2), .nf(1), .l(300n)) (*
integer library_binding
 = "/*Target Process Technology*/";
integer passed_mfactor = "m";
 *)
M17 ( S, Q, net20, vdd );
pch #(.w(3u), .m(2), .nf(1), .l(300n)) (*
integer library_binding
 = "/*Target Process Technology*/";
integer passed_mfactor = "m";
 *)
M18 ( R, QB, net20, vdd );
pch #(.w(2u), .m(2), .nf(1), .l(2u)) (*
integer library_binding
 = "/*Target Process Technology*/";
integer passed_mfactor = "m";
 *)
M9 ( vbn, IREF, vdd,
vdd );
pch #(.w(4u), .m(1), .nf(2), .l(2u)) (*
integer library_binding
 = "/*Target Process Technology*/";
integer passed_mfactor = "m";
 *)
M102 ( net046, net046,
net32, net32 );
pch #(.w(2u), .m(2), .nf(1), .l(300n)) (*
integer library_binding
 = "/*Target Process Technology*/";
integer passed_mfactor = "m";
 *)
M33 ( QB, ZN_2, vdd,
vdd );
pch #(.w(2u), .m(8), .nf(1), .l(2u)) (*
integer library_binding
 = "/*Target Process Technology*/";
integer passed_mfactor = "m";
 *)
M10 ( net20, IREF, vdd,
vdd );
pch #(.w(2u), .m(2), .nf(1), .l(300n)) (*
integer library_binding
 = "/*Target Process Technology*/";
integer passed_mfactor = "m";
 *)
M30 ( ZN_2, R, net0127,
vdd );
pch #(.w(2u), .m(2), .nf(1), .l(300n)) (*
integer library_binding
 = "/*Target Process Technology*/";
integer passed_mfactor = "m";
 *)
M29 ( net0127, ZN_1,
vdd, vdd );
pch #(.w(2u), .m(2), .nf(1), .l(4u)) (*
integer library_binding
 = "/*Target Process Technology*/";
integer passed_mfactor = "m";
 *)
M12 ( vampgate, net012,
vdd, vdd );
pch #(.w(2u), .m(2), .nf(1), .l(300n)) (*
integer library_binding
 = "/*Target Process Technology*/";
integer passed_mfactor = "m";
 *)
M32 ( net0104, QB,
vdd_pin, vdd_pin );
pch #(.w(2u), .m(2), .nf(1), .l(300n)) (*
integer library_binding
 = "/*Target Process Technology*/";
integer passed_mfactor = "m";
 *)
M31 ( QBP, net0104,
vdd_pin, vdd_pin );
pch #(.w(2u), .m(1), .nf(1), .l(2u)) (*
integer library_binding
 = "/*Target Process Technology*/";
integer passed_mfactor = "m";
 *)
M8 ( IREF, IREF, vdd,
vdd );
pch #(.w(2u), .m(2), .nf(1), .l(4u)) (*
integer library_binding
 = "/*Target Process Technology*/";
integer passed_mfactor = "m";
 *)
M11 ( net012, net012,
vdd, vdd );
pch #(.w(4u), .m(1), .nf(2), .l(2u)) (*
integer library_binding
 = "/*Target Process Technology*/";
integer passed_mfactor = "m";
 *)
M103 ( net033, net033,
net046, net046 );
pch #(.w(4u), .m(1), .nf(2), .l(2u)) (*
integer library_binding
 = "/*Target Process Technology*/";
integer passed_mfactor = "m";
 *)
M105 ( gnd, gnd, net29,
net29 );
pch #(.w(4u), .m(1), .nf(2), .l(2u)) (*
integer library_binding
 = "/*Target Process Technology*/";
integer passed_mfactor = "m";
 *)
M101 ( net32, net32,
vdd, vdd );
pch #(.w(4u), .m(1), .nf(2), .l(2u)) (*
integer library_binding
 = "/*Target Process Technology*/";
integer passed_mfactor = "m";
 *)
M104 ( net29, net29,
net033, net033 );

nch #(.w(2u), .m(1), .nf(1), .l(2u)) (*
integer library_binding
 = "/*Target Process Technology*/";
integer passed_mfactor = "m";
 *)
M7 ( vbn, vbn, gnd, gnd );

nch #(.w(2u), .m(1), .nf(1), .l(350.0n)) (*
integer library_binding
 = "/*Target Process Technology*/";
integer passed_mfactor = "m";
 *)
M16 ( ZN_1, S, gnd, gnd );
nch #(.w(2u), .m(1), .nf(1), .l(350.0n)) (*
integer library_binding
 = "/*Target Process Technology*/";
integer passed_mfactor = "m";
 *)
M0 ( ZN_1, ZN_2, gnd,
gnd );
nch #(.w(2u), .m(1), .nf(1), .l(1.5u)) (*
integer library_binding
 = "/*Target Process Technology*/";
integer passed_mfactor = "m";
 *)
M20 ( VC1, Q, gnd, gnd );
nch #(.w(2u), .m(1), .nf(1), .l(1.5u)) (*
integer library_binding
 = "/*Target Process Technology*/";
integer passed_mfactor = "m";
 *)
M19 ( VC0, QB, gnd, gnd );
nch #(.w(2u), .m(1), .nf(1), .l(350.0n)) (*
integer library_binding
 = "/*Target Process Technology*/";
integer passed_mfactor = "m";
 *)
M34 ( ZN_2, R, gnd, gnd );
nch #(.w(3u), .m(1), .nf(1), .l(1u)) (*
integer library_binding
 = "/*Target Process Technology*/";
integer passed_mfactor = "m";
 *)
M25 ( vampgate,
vampgate, net11, gnd );
nch #(.w(1.5u), .m(1), .nf(1), .l(350.0n)) (*
integer library_binding
 = "/*Target Process Technology*/";
integer passed_mfactor = "m";
 *)
M14 ( Q, ZN_1, gnd, gnd );
nch #(.w(2u), .m(1), .nf(1), .l(2u)) (*
integer library_binding
 = "/*Target Process Technology*/";
integer passed_mfactor = "m";
 *)
M21 ( net10, vbn, gnd,
gnd );
nch #(.w(1.5u), .m(1), .nf(1), .l(350.0n)) (*
integer library_binding
 = "/*Target Process Technology*/";
integer passed_mfactor = "m";
 *)
M15 ( QB, ZN_2, gnd,
gnd );
nch #(.w(1.5u), .m(1), .nf(1), .l(350.0n)) (*
integer library_binding
 = "/*Target Process Technology*/";
integer passed_mfactor = "m";
 *)
M36 ( net0104, QB, gnd,
gnd );
nch #(.w(3u), .m(1), .nf(1), .l(1u)) (*
integer library_binding
 = "/*Target Process Technology*/";
integer passed_mfactor = "m";
 *)
M27 ( R, vampgate, VC0,
gnd );
nch #(.w(1.5u), .m(1), .nf(1), .l(350.0n)) (*
integer library_binding
 = "/*Target Process Technology*/";
integer passed_mfactor = "m";
 *)
M38 ( QP, net0105, gnd,
gnd );
nch #(.w(3u), .m(1), .nf(1), .l(1u)) (*
integer library_binding
 = "/*Target Process Technology*/";
integer passed_mfactor = "m";
 *)
M26 ( net012, vampgate,
net42, gnd );
nch #(.w(5u), .m(1), .nf(1), .l(1u)) (*
integer library_binding
 = "/*Target Process Technology*/";
integer passed_mfactor = "m";
 *)
M23 ( net11, net11,
net10, gnd );
nch #(.w(1.5u), .m(1), .nf(1), .l(350.0n)) (*
integer library_binding
 = "/*Target Process Technology*/";
integer passed_mfactor = "m";
 *)
M37 ( net0105, Q, gnd,
gnd );
nch #(.w(2u), .m(1), .nf(1), .l(350.0n)) (*
integer library_binding
 = "/*Target Process Technology*/";
integer passed_mfactor = "m";
 *)
M35 ( ZN_2, ZN_1, gnd,
gnd );
nch #(.w(3u), .m(1), .nf(1), .l(1u)) (*
integer library_binding
 = "/*Target Process Technology*/";
integer passed_mfactor = "m";
 *)
M28 ( S, vampgate, VC1,
gnd );
nch #(.w(5u), .m(1), .nf(1), .l(1u)) (*
integer library_binding
 = "/*Target Process Technology*/";
integer passed_mfactor = "m";
 *)
M24 ( net42, net033,
net10, gnd );
nch #(.w(1.5u),.m(1), .nf(1), .l(350.0n)) (*
integer library_binding
 = "/*Target Process Technology*/";
integer passed_mfactor = "m";
 *)
M13 ( QBP, net0104, gnd,
gnd );

mimcap_2p0_sin #(.mf(1), .wt(12.0u), .lt(17.0u)) (*

integer library_binding = "/*Target Process Technology*/";
 *)
C3 ( IREF, vdd );
mimcap_2p0_sin #(.mf(1), .wt(12.0u), .lt(17.0u)) (*

integer library_binding = "/*Target Process Technology*/";
 *)
C2 ( IREF, vdd );
mimcap_2p0_sin #(.mf(1), .wt(4.79u), .lt(4.79u)) (*

integer library_binding = "/*Target Process Technology*/";
 *)
C0 ( VC0, gnd );
mimcap_2p0_sin #(.mf(1), .wt(4.79u), .lt(4.79u)) (*

integer library_binding = "/*Target Process Technology*/";
 *)
C1 ( VC1, gnd );

endmodule
